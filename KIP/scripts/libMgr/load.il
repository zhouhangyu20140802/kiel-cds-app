loadi( strcat(kip_path "/scripts/libMgr/kipLibMgrCallback.il") )
loadi( strcat(kip_path "/scripts/libMgr/kipIPLibInitCallback.il") )
loadi( strcat(kip_path "/scripts/libMgr/kipIPUploadCallback.il") )
loadi( strcat(kip_path "/scripts/libMgr/kipCellViewEncrypt.il") )
loadi( strcat(kip_path "/scripts/libMgr/kipLibMgrEncrypt.il") )
