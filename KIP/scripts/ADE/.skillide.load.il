loadi( strcat(kip_path "/scripts/ADE/kipADECallback.il") )
loadi( strcat(kip_path "/scripts/ADE/kipADEDecrypt.il") )
loadi( strcat(kip_path "/scripts/ADE/kipADEEncrypt.il") )
