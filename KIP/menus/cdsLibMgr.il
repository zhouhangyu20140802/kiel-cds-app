load( strcat(getShellEnvVar("KIP_PATH") "/menus/kipLibMgr.il") )
load( strcat(getShellEnvVar("CDSGIT_PATH") "/menus/cdsLibMgr.menu") )
